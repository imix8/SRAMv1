ADE simulation setup
Run mode: Single Run, Sweeps and Corners
Tests:
  ECE4130_Project_RegisterDecoder_1: ECE4130_Project/RegisterDecoder/schematic, simulator spectre
