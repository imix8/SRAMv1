ADE simulation setup
Run mode: Single Run, Sweeps and Corners
Tests:
  ECE4130_Project_4to16DecoderActiveHigh_1: ECE4130_Project/4to16DecoderActiveHigh/schematic, simulator spectre
