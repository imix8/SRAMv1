ADE simulation setup
Run mode: Single Run, Sweeps and Corners
Tests:
  ECE4130_Project_Register6Bit_1: ECE4130_Project/Register6Bit/schematic, simulator spectre
