ADE simulation setup
Run mode: Single Run, Sweeps and Corners
Tests:
  ECE4130_Project_4to1Mux_1: ECE4130_Project/4to1Mux/schematic, simulator spectre
