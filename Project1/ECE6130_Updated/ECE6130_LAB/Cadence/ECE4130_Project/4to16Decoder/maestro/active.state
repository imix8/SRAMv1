ADE simulation setup
Test ECE4130_Project_4to16Decoder_1: ECE4130_Project/4to16Decoder/schematic, simulator spectre
  Models: /nethome/imix3/ECE4130_M/Project1/ECE6130_Updated/ECE6130_LAB/Cadence/INC/NMOS_THKOX.inc, /nethome/imix3/ECE4130_M/Project1/ECE6130_Updated/ECE6130_LAB/Cadence/INC/NMOS_VTG.inc, /nethome/imix3/ECE4130_M/Project1/ECE6130_Updated/ECE6130_LAB/Cadence/INC/NMOS_VTH.inc, /nethome/imix3/ECE4130_M/Project1/ECE6130_Updated/ECE6130_LAB/Cadence/INC/NMOS_VTL.inc, /nethome/imix3/ECE4130_M/Project1/ECE6130_Updated/ECE6130_LAB/Cadence/INC/PMOS_THKOX.inc, /nethome/imix3/ECE4130_M/Project1/ECE6130_Updated/ECE6130_LAB/Cadence/INC/PMOS_VTG.inc, /nethome/imix3/ECE4130_M/Project1/ECE6130_Updated/ECE6130_LAB/Cadence/INC/PMOS_VTH.inc, /nethome/imix3/ECE4130_M/Project1/ECE6130_Updated/ECE6130_LAB/Cadence/INC/PMOS_VTL.inc
  Temperature: 27
  Stimulus vdd!: voltage dc dc=800.0m srcType=dc
  Stimulus S0: voltage pulse val0=0 val1=800.0m period=2n srcType=pulse
  Stimulus S1: voltage dc dc=0 srcType=dc
  Stimulus S2: voltage pulse val0=0 val1=800.0m period=2n srcType=pulse
  Stimulus S3: voltage dc dc=0 srcType=dc
  Stimulus CLK: voltage pulse val0=0 val1=800.0m period=1n rise=100p fall=100p srcType=pulse
  Analysis tran: stop=4n
  Signals: /S0, /S2, /WL0, /WL5, /CLK
Run mode: Single Run, Sweeps and Corners
