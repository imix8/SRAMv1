ADE simulation setup
Test ECE4130_Project_SRAMCircuit_1: ECE4130_Project/SRAMCircuit/schematic, simulator spectre
  Models: /nethome/ccarpenter38/ECE4130_M/Project1/ECE6130_Updated/ECE6130_LAB/Cadence/INC/NMOS_THKOX.inc, /nethome/ccarpenter38/ECE4130_M/Project1/ECE6130_Updated/ECE6130_LAB/Cadence/INC/NMOS_VTG.inc, /nethome/ccarpenter38/ECE4130_M/Project1/ECE6130_Updated/ECE6130_LAB/Cadence/INC/NMOS_VTH.inc, /nethome/ccarpenter38/ECE4130_M/Project1/ECE6130_Updated/ECE6130_LAB/Cadence/INC/NMOS_VTL.inc, /nethome/ccarpenter38/ECE4130_M/Project1/ECE6130_Updated/ECE6130_LAB/Cadence/INC/PMOS_THKOX.inc, /nethome/ccarpenter38/ECE4130_M/Project1/ECE6130_Updated/ECE6130_LAB/Cadence/INC/PMOS_VTG.inc, /nethome/ccarpenter38/ECE4130_M/Project1/ECE6130_Updated/ECE6130_LAB/Cadence/INC/PMOS_VTH.inc, /nethome/ccarpenter38/ECE4130_M/Project1/ECE6130_Updated/ECE6130_LAB/Cadence/INC/PMOS_VTL.inc
  Temperature: 27
  Stimulus vdd!: voltage dc dc=800.0m srcType=dc
  Stimulus clk: voltage pulse val0=0 val1=800.0m period=1n rise=100p fall=100p srcType=pulse
  Stimulus rIn0: voltage pwl delay=-150p pwlfilter=  tvpairs=8 t1=3n v1=0 t2=3.1n v2=800.0m t3=4n v3=800.0m t4=4.1n v4=0 t5=6n v5=0 t6=6.1n v6=800.0m t7=7n v7=800.0m t8=7.1n v8=0 v9=0 v10=0 v11=0 v12=0 v13=0 v14=0 v15=0 v16=0 v17=0 v18=0 v19=0 v20=0 v21=0 v22=0 v23=0 v24=0 v25=0 v26=0 v27=0 v28=0 v29=0 v30=0 v31=0 v32=0 v33=0 v34=0 v35=0 v36=0 v37=0 v38=0 v39=0 v40=0 v41=0 v42=0 v43=0 v44=0 v45=0 v46=0 v47=0 v48=0 v49=0 v50=0 srcType=pwl
  Stimulus rIn1: voltage pwl delay=-150p pwlfilter=  tvpairs=8 t1=4n v1=0 t2=4.1n v2=800.0m t3=5n v3=800.0m t4=5.1n v4=0 t5=7n v5=0 t6=7.1n v6=800.0m t7=8n v7=800.0m t8=8.1n v8=0 v9=0 v10=0 v11=0 v12=0 v13=0 v14=0 v15=0 v16=0 v17=0 v18=0 v19=0 v20=0 v21=0 v22=0 v23=0 v24=0 v25=0 v26=0 v27=0 v28=0 v29=0 v30=0 v31=0 v32=0 v33=0 v34=0 v35=0 v36=0 v37=0 v38=0 v39=0 v40=0 v41=0 v42=0 v43=0 v44=0 v45=0 v46=0 v47=0 v48=0 v49=0 v50=0 srcType=pwl
  Stimulus rIn2: voltage dc srcType=dc
  Stimulus rIn3: voltage dc srcType=dc
  Stimulus cIn0: voltage dc srcType=dc
  Stimulus cIn1: voltage dc srcType=dc
  Stimulus WE: voltage pwl pwlfilter=  tvpairs=4 t1=2n v1=0 t2=2.1n v2=800.0m t3=5n v3=800.0m t4=5.1n v4=0 v5=0 v6=0 v7=0 v8=0 v9=0 v10=0 v11=0 v12=0 v13=0 v14=0 v15=0 v16=0 v17=0 v18=0 v19=0 v20=0 v21=0 v22=0 v23=0 v24=0 v25=0 v26=0 v27=0 v28=0 v29=0 v30=0 v31=0 v32=0 v33=0 v34=0 v35=0 v36=0 v37=0 v38=0 v39=0 v40=0 v41=0 v42=0 v43=0 v44=0 v45=0 v46=0 v47=0 v48=0 v49=0 v50=0 srcType=pwl
  Stimulus Write0: voltage dc dc=800.0m srcType=dc
  Stimulus Write1: voltage pwl delay=-150p pwlfilter=  tvpairs=8 t1=3n v1=0 t2=3.1n v2=800.0m t3=4n v3=800.0m t4=4.1n v4=0 t5=6n v5=0 t6=6.1n v6=800.0m t7=7n v7=800.0m t8=7.1n v8=0 v9=0 v10=0 v11=0 v12=0 v13=0 v14=0 v15=0 v16=0 v17=0 v18=0 v19=0 v20=0 v21=0 v22=0 v23=0 v24=0 v25=0 v26=0 v27=0 v28=0 v29=0 v30=0 v31=0 v32=0 v33=0 v34=0 v35=0 v36=0 v37=0 v38=0 v39=0 v40=0 v41=0 v42=0 v43=0 v44=0 v45=0 v46=0 v47=0 v48=0 v49=0 v50=0 srcType=pwl
  Stimulus Write2: voltage pwl delay=-150p pwlfilter=  tvpairs=8 t1=4n v1=0 t2=4.1n v2=800.0m t3=5n v3=800.0m t4=5.1n v4=0 t5=7n v5=0 t6=7.1n v6=800.0m t7=8n v7=800.0m t8=8.1n v8=0 v9=0 v10=0 v11=0 v12=0 v13=0 v14=0 v15=0 v16=0 v17=0 v18=0 v19=0 v20=0 v21=0 v22=0 v23=0 v24=0 v25=0 v26=0 v27=0 v28=0 v29=0 v30=0 v31=0 v32=0 v33=0 v34=0 v35=0 v36=0 v37=0 v38=0 v39=0 v40=0 v41=0 v42=0 v43=0 v44=0 v45=0 v46=0 v47=0 v48=0 v49=0 v50=0 srcType=pwl
  Stimulus Write3: voltage dc dc=800.0m srcType=dc
  Stimulus Write4: voltage dc dc=800.0m srcType=dc
  Stimulus Write5: voltage dc dc=800.0m srcType=dc
  Stimulus Write6: voltage dc dc=800.0m srcType=dc
  Stimulus Write7: voltage dc dc=800.0m srcType=dc
  Analysis tran: stop=9n
  Signals: /Read0, /Read1, /Read2, /Read3, /Read4, /Read5, /Read6, /Read7, /clk, /WE, /w0, /w1, /w2, /I1/wr0, /I1/wr1, /I1/wr2, /net11, /net43, /I0/I7/I0/net9, /I0/I7/I0/net2, /I1/L1, /I1/nL1, /I1/r1, /I1/w0
Run mode: Single Run, Sweeps and Corners
