ADE simulation setup
Run mode: Single Run, Sweeps and Corners
Tests:
  ECE4130_Project_2to4Decoder_1: ECE4130_Project/2to4Decoder/schematic, simulator spectre
