ADE simulation setup
Run mode: Single Run, Sweeps and Corners
Tests:
  ECE4130_Project_inverter_1: ECE4130_Project/inverter/schematic, simulator spectre
