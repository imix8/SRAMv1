ADE simulation setup
Test ECE4130_Project_2to4DecoderEnable_1: ECE4130_Project/2to4DecoderEnable/schematic, simulator spectre
  Models: /nethome/smin63/ECE4130/ECE6130_Updated/ECE6130_LAB/Cadence/INC/NMOS_THKOX.inc, /nethome/smin63/ECE4130/ECE6130_Updated/ECE6130_LAB/Cadence/INC/NMOS_VTG.inc, /nethome/smin63/ECE4130/ECE6130_Updated/ECE6130_LAB/Cadence/INC/NMOS_VTH.inc, /nethome/smin63/ECE4130/ECE6130_Updated/ECE6130_LAB/Cadence/INC/NMOS_VTL.inc, /nethome/smin63/ECE4130/ECE6130_Updated/ECE6130_LAB/Cadence/INC/PMOS_THKOX.inc, /nethome/smin63/ECE4130/ECE6130_Updated/ECE6130_LAB/Cadence/INC/PMOS_VTG.inc, /nethome/smin63/ECE4130/ECE6130_Updated/ECE6130_LAB/Cadence/INC/PMOS_VTH.inc, /nethome/smin63/ECE4130/ECE6130_Updated/ECE6130_LAB/Cadence/INC/PMOS_VTL.inc
  Temperature: 27
  Stimulus vdd!: voltage dc dc=1 srcType=dc
  Stimulus S0: voltage pulse val0=1 val1=0 period=4n srcType=pulse
  Stimulus S1: voltage pulse val0=1 val1=0 period=8n srcType=pulse
  Stimulus E: voltage pulse val0=1 val1=0 period=2n srcType=pulse
  Analysis tran: stop=8n
  Signals: /S0, /E, /S1, /I0, /I1, /I2, /I3
Run mode: Single Run, Sweeps and Corners
