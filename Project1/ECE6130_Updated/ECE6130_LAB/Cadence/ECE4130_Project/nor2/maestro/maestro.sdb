ADE simulation setup
Run mode: Single Run, Sweeps and Corners
Tests:
  ECE4130_Project_AnorB_1: ECE4130_Project/nor2/schematic, simulator spectre
