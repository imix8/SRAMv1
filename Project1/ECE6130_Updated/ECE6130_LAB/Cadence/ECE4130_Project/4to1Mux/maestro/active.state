ADE simulation setup
Test ECE4130_Project_4to1Mux_1: ECE4130_Project/4to1Mux/schematic, simulator spectre
  Models: /nethome/ccarpenter38/ECE6130_Updated/ECE6130_LAB/Cadence/INC/NMOS_THKOX.inc, /nethome/ccarpenter38/ECE6130_Updated/ECE6130_LAB/Cadence/INC/NMOS_VTG.inc, /nethome/ccarpenter38/ECE6130_Updated/ECE6130_LAB/Cadence/INC/NMOS_VTH.inc, /nethome/ccarpenter38/ECE6130_Updated/ECE6130_LAB/Cadence/INC/NMOS_VTL.inc, /nethome/ccarpenter38/ECE6130_Updated/ECE6130_LAB/Cadence/INC/PMOS_THKOX.inc, /nethome/ccarpenter38/ECE6130_Updated/ECE6130_LAB/Cadence/INC/PMOS_VTG.inc, /nethome/ccarpenter38/ECE6130_Updated/ECE6130_LAB/Cadence/INC/PMOS_VTH.inc, /nethome/ccarpenter38/ECE6130_Updated/ECE6130_LAB/Cadence/INC/PMOS_VTL.inc
  Temperature: 27
  Stimulus vdd!: voltage dc dc=800.0m srcType=dc
  Stimulus In0: voltage dc dc=0 srcType=dc
  Stimulus In1: voltage dc dc=800.0m srcType=dc
  Stimulus In2: voltage dc dc=0 srcType=dc
  Stimulus In3: voltage dc dc=0 srcType=dc
  Stimulus S0: voltage pulse val0=800.0m val1=0 period=2n rise=100p fall=100p srcType=pulse
  Stimulus S1: voltage pulse val0=800.0m val1=0 period=1n rise=100p fall=100p srcType=pulse
  Analysis tran: stop=4n
  Signals: /S0, /S1, /Out
Run mode: Single Run, Sweeps and Corners
