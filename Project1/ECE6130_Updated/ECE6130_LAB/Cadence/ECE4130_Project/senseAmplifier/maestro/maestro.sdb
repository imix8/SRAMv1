ADE simulation setup
Run mode: Single Run, Sweeps and Corners
Tests:
  ECE4130_Project_senseAmplifier_1: ECE4130_Project/senseAmplifier/schematic, simulator spectre
