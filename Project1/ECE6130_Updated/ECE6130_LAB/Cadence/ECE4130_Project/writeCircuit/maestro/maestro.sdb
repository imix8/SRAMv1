ADE simulation setup
Run mode: Single Run, Sweeps and Corners
Tests:
  ECE4130_Project_writeCircuit_1: ECE4130_Project/writeCircuit/schematic, simulator spectre
