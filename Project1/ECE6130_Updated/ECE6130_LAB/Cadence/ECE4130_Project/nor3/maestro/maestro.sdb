ADE simulation setup
Run mode: Single Run, Sweeps and Corners
Tests:
  ECE4130_Project_nor3_1: ECE4130_Project/nor3/schematic, simulator spectre
