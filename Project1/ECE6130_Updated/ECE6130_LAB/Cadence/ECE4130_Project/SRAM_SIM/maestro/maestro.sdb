ADE simulation setup
Run mode: Single Run, Sweeps and Corners
Tests:
  ECE4130_Project_SRAM_SIM_1: ECE4130_Project/SRAM_SIM/schematic, simulator spectre
