ADE simulation setup
Test Tutorial_myInverter_1: Tutorial/myInverter/schematic, simulator spectre
  Models: /nethome/ccarpenter38/ECE6130_Updated/ECE6130_LAB/Cadence/INC/NMOS_THKOX.inc, /nethome/ccarpenter38/ECE6130_Updated/ECE6130_LAB/Cadence/INC/NMOS_VTG.inc, /nethome/ccarpenter38/ECE6130_Updated/ECE6130_LAB/Cadence/INC/NMOS_VTH.inc, /nethome/ccarpenter38/ECE6130_Updated/ECE6130_LAB/Cadence/INC/NMOS_VTL.inc, /nethome/ccarpenter38/ECE6130_Updated/ECE6130_LAB/Cadence/INC/PMOS_THKOX.inc, /nethome/ccarpenter38/ECE6130_Updated/ECE6130_LAB/Cadence/INC/PMOS_VTG.inc, /nethome/ccarpenter38/ECE6130_Updated/ECE6130_LAB/Cadence/INC/PMOS_VTH.inc, /nethome/ccarpenter38/ECE6130_Updated/ECE6130_LAB/Cadence/INC/PMOS_VTL.inc
  Temperature: 27
  Analysis tran: stop=4n errpreset=conservative
  Signals: /net6, /net4
Run mode: Single Run, Sweeps and Corners
