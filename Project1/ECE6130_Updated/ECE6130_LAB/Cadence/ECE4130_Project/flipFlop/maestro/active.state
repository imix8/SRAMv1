ADE simulation setup
Test ECE4130_Project_flipFlop_1: ECE4130_Project/flipFlop/schematic, simulator spectre
  Models: /nethome/ccarpenter38/ECE6130_Updated/ECE6130_LAB/Cadence/INC/NMOS_THKOX.inc, /nethome/ccarpenter38/ECE6130_Updated/ECE6130_LAB/Cadence/INC/NMOS_VTG.inc, /nethome/ccarpenter38/ECE6130_Updated/ECE6130_LAB/Cadence/INC/NMOS_VTH.inc, /nethome/ccarpenter38/ECE6130_Updated/ECE6130_LAB/Cadence/INC/NMOS_VTL.inc, /nethome/ccarpenter38/ECE6130_Updated/ECE6130_LAB/Cadence/INC/PMOS_THKOX.inc, /nethome/ccarpenter38/ECE6130_Updated/ECE6130_LAB/Cadence/INC/PMOS_VTG.inc, /nethome/ccarpenter38/ECE6130_Updated/ECE6130_LAB/Cadence/INC/PMOS_VTH.inc, /nethome/ccarpenter38/ECE6130_Updated/ECE6130_LAB/Cadence/INC/PMOS_VTL.inc
  Temperature: 27
  Stimulus vdd!: voltage dc dc=550.0m srcType=dc
  Stimulus clk: voltage pulse val0=550.0m val1=0 period=1n rise=100p fall=100p srcType=pulse
  Stimulus D: voltage pulse val0=550.0m val1=0 period=2n delay=250p rise=100p fall=100p srcType=pulse
  Analysis dc: sweep t start=0p stop=9p step=1p
  Analysis tran: stop=3n
  Signals: /Q, /clk, /D
Run mode: Single Run, Sweeps and Corners
