ADE simulation setup
Run mode: Single Run, Sweeps and Corners
Tests:
  ECE4130_Project_4to16Decoder_1: ECE4130_Project/4to16Decoder/schematic, simulator spectre
    Outputs: /WL0; /WL1; /WL2; /WL3; /WL4; /WL5; /WL6; "/WL7"; /WL7; /WL8; /WL9; /WL10; /WL11; /WL12; /WL13; /WL14; /WL15
