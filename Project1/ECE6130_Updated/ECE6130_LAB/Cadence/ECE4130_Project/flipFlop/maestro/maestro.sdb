ADE simulation setup
Run mode: Single Run, Sweeps and Corners
Tests:
  ECE4130_Project_flipFlop_1: ECE4130_Project/flipFlop/schematic, simulator spectre
