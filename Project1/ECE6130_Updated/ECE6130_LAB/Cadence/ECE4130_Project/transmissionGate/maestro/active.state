ADE simulation setup
Test ECE4130_Project_transmissionGate_1: ECE4130_Project/transmissionGate/schematic, simulator spectre
  Models: /nethome/ccarpenter38/ECE6130_Updated/ECE6130_LAB/Cadence/INC/NMOS_THKOX.inc, /nethome/ccarpenter38/ECE6130_Updated/ECE6130_LAB/Cadence/INC/NMOS_VTG.inc, /nethome/ccarpenter38/ECE6130_Updated/ECE6130_LAB/Cadence/INC/NMOS_VTH.inc, /nethome/ccarpenter38/ECE6130_Updated/ECE6130_LAB/Cadence/INC/NMOS_VTL.inc, /nethome/ccarpenter38/ECE6130_Updated/ECE6130_LAB/Cadence/INC/PMOS_THKOX.inc, /nethome/ccarpenter38/ECE6130_Updated/ECE6130_LAB/Cadence/INC/PMOS_VTG.inc, /nethome/ccarpenter38/ECE6130_Updated/ECE6130_LAB/Cadence/INC/PMOS_VTH.inc, /nethome/ccarpenter38/ECE6130_Updated/ECE6130_LAB/Cadence/INC/PMOS_VTL.inc
  Temperature: 27
  Stimulus vdd!: voltage dc dc=800.0m srcType=dc
  Stimulus In: voltage pulse val0=0 val1=800.0m period=1n rise=100p fall=100p srcType=pulse
  Stimulus pGate: voltage dc dc=0 srcType=dc
  Stimulus nGate: voltage dc dc=800.0m srcType=dc
  Analysis tran: stop=4n errpreset=conservative
  Signals: /In, /Out
