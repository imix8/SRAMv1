ADE simulation setup
Test ECE4130_Project_flipFlop_1: ECE4130_Project/flipFlop/schematic, simulator spectre
  Models: /nethome/ccarpenter38/ECE6130_Updated/ECE6130_LAB/Cadence/INC/NMOS_THKOX.inc, /nethome/ccarpenter38/ECE6130_Updated/ECE6130_LAB/Cadence/INC/NMOS_VTG.inc, /nethome/ccarpenter38/ECE6130_Updated/ECE6130_LAB/Cadence/INC/NMOS_VTH.inc, /nethome/ccarpenter38/ECE6130_Updated/ECE6130_LAB/Cadence/INC/NMOS_VTL.inc, /nethome/ccarpenter38/ECE6130_Updated/ECE6130_LAB/Cadence/INC/PMOS_THKOX.inc, /nethome/ccarpenter38/ECE6130_Updated/ECE6130_LAB/Cadence/INC/PMOS_VTG.inc, /nethome/ccarpenter38/ECE6130_Updated/ECE6130_LAB/Cadence/INC/PMOS_VTH.inc, /nethome/ccarpenter38/ECE6130_Updated/ECE6130_LAB/Cadence/INC/PMOS_VTL.inc
  Temperature: 27
  Stimulus vdd!: voltage dc dc=800.0m srcType=dc
  Stimulus clk: voltage pulse val0=800.0m val1=0 period=1n rise=100p fall=100p srcType=pulse
  Stimulus D: voltage pulse val0=800.0m val1=0 period=2.5n rise=100p fall=100p srcType=pulse
  Analysis tran: stop=8n
  Signals: /Q, /clk
Run mode: Single Run, Sweeps and Corners
