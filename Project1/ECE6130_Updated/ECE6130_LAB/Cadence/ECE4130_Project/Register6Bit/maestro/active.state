ADE simulation setup
Test ECE4130_Project_Register6Bit_1: ECE4130_Project/Register6Bit/schematic, simulator spectre
  Models: /nethome/ccarpenter38/ECE4130_M/Project1/ECE6130_Updated/ECE6130_LAB/Cadence/INC/NMOS_THKOX.inc, /nethome/ccarpenter38/ECE4130_M/Project1/ECE6130_Updated/ECE6130_LAB/Cadence/INC/NMOS_VTG.inc, /nethome/ccarpenter38/ECE4130_M/Project1/ECE6130_Updated/ECE6130_LAB/Cadence/INC/NMOS_VTH.inc, /nethome/ccarpenter38/ECE4130_M/Project1/ECE6130_Updated/ECE6130_LAB/Cadence/INC/NMOS_VTL.inc, /nethome/ccarpenter38/ECE4130_M/Project1/ECE6130_Updated/ECE6130_LAB/Cadence/INC/PMOS_THKOX.inc, /nethome/ccarpenter38/ECE4130_M/Project1/ECE6130_Updated/ECE6130_LAB/Cadence/INC/PMOS_VTG.inc, /nethome/ccarpenter38/ECE4130_M/Project1/ECE6130_Updated/ECE6130_LAB/Cadence/INC/PMOS_VTH.inc, /nethome/ccarpenter38/ECE4130_M/Project1/ECE6130_Updated/ECE6130_LAB/Cadence/INC/PMOS_VTL.inc
  Temperature: 27
  Stimulus vdd!: voltage dc dc=800.0m srcType=dc
  Stimulus D2: voltage dc dc=800.0m srcType=dc
  Stimulus D3: voltage dc dc=800.0m srcType=dc
  Stimulus D4: voltage dc dc=800.0m srcType=dc
  Stimulus D5: voltage dc dc=800.0m srcType=dc
  Stimulus clk: voltage pulse val0=0 val1=800.0m period=1n rise=100p fall=100p srcType=pulse
  Stimulus D0: voltage dc dc=800.0m srcType=dc
  Stimulus D1: voltage dc dc=800.0m srcType=dc
  Analysis tran: stop=3n
  Signals: /Q0, /clk
Run mode: Single Run, Sweeps and Corners
