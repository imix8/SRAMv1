ADE simulation setup
Test ECE4130_Project_4to16DecoderActiveHigh_1: ECE4130_Project/4to16DecoderActiveHigh/schematic, simulator spectre
  Models: /nethome/ccarpenter38/ECE6130_Updated/ECE6130_LAB/Cadence/INC/NMOS_THKOX.inc, /nethome/ccarpenter38/ECE6130_Updated/ECE6130_LAB/Cadence/INC/NMOS_VTG.inc, /nethome/ccarpenter38/ECE6130_Updated/ECE6130_LAB/Cadence/INC/NMOS_VTH.inc, /nethome/ccarpenter38/ECE6130_Updated/ECE6130_LAB/Cadence/INC/NMOS_VTL.inc, /nethome/ccarpenter38/ECE6130_Updated/ECE6130_LAB/Cadence/INC/PMOS_THKOX.inc, /nethome/ccarpenter38/ECE6130_Updated/ECE6130_LAB/Cadence/INC/PMOS_VTG.inc, /nethome/ccarpenter38/ECE6130_Updated/ECE6130_LAB/Cadence/INC/PMOS_VTH.inc, /nethome/ccarpenter38/ECE6130_Updated/ECE6130_LAB/Cadence/INC/PMOS_VTL.inc
  Temperature: 27
  Stimulus vdd!: voltage dc dc=800.0m srcType=dc
  Stimulus clk: voltage pulse val0=800.0m val1=0 period=1n rise=100.0p fall=100.0p srcType=pulse
  Stimulus S0: voltage dc dc=0 srcType=dc
  Stimulus S1: voltage pulse val0=0 val1=800.0m period=2.75n rise=100.0p fall=100.0p srcType=pulse
  Stimulus S2: voltage dc dc=0 srcType=dc
  Stimulus S3: voltage dc dc=0 srcType=dc
  Analysis tran: stop=8n
  Signals: /WL0, /clk, /S1, /WL4
Run mode: Single Run, Sweeps and Corners
