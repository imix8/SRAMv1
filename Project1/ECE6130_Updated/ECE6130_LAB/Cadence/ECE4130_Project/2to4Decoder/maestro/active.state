ADE simulation setup
Test ECE4130_Project_2to4Decoder_1: ECE4130_Project/2to4Decoder/schematic, simulator spectre
  Models: /nethome/imix3/ECE4130_M/Project1/ECE6130_Updated/ECE6130_LAB/Cadence/INC/NMOS_THKOX.inc, /nethome/imix3/ECE4130_M/Project1/ECE6130_Updated/ECE6130_LAB/Cadence/INC/NMOS_VTG.inc, /nethome/imix3/ECE4130_M/Project1/ECE6130_Updated/ECE6130_LAB/Cadence/INC/NMOS_VTH.inc, /nethome/imix3/ECE4130_M/Project1/ECE6130_Updated/ECE6130_LAB/Cadence/INC/NMOS_VTL.inc, /nethome/imix3/ECE4130_M/Project1/ECE6130_Updated/ECE6130_LAB/Cadence/INC/PMOS_THKOX.inc, /nethome/imix3/ECE4130_M/Project1/ECE6130_Updated/ECE6130_LAB/Cadence/INC/PMOS_VTG.inc, /nethome/imix3/ECE4130_M/Project1/ECE6130_Updated/ECE6130_LAB/Cadence/INC/PMOS_VTH.inc, /nethome/imix3/ECE4130_M/Project1/ECE6130_Updated/ECE6130_LAB/Cadence/INC/PMOS_VTL.inc
  Temperature: 27
  Stimulus S1: voltage pulse val0=1 val1=0 period=3n srcType=pulse
  Stimulus S0: voltage pulse val0=1 val1=0 period=2n srcType=pulse
  Stimulus vdd!: voltage dc dc=1 srcType=dc
  Analysis tran: stop=8n
  Signals: /I0, /I1, /I2, /I3, /S0, /S1
Run mode: Single Run, Sweeps and Corners
