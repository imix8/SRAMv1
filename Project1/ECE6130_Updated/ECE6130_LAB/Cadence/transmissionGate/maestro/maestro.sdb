ADE simulation setup
Run mode: Single Run, Sweeps and Corners
Tests:
  ECE4130_Project_transmissionGate_1: ECE4130_Project/transmissionGate/schematic, simulator spectre
    Outputs: /In
