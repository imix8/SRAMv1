ADE simulation setup
Test ECE4130_Project_4to16Decoder_1: ECE4130_Project/4to16Decoder/schematic, simulator spectre
  Models: /nethome/smin63/ECE4130/ECE6130_Updated/ECE6130_LAB/Cadence/INC/NMOS_THKOX.inc, /nethome/smin63/ECE4130/ECE6130_Updated/ECE6130_LAB/Cadence/INC/NMOS_VTG.inc, /nethome/smin63/ECE4130/ECE6130_Updated/ECE6130_LAB/Cadence/INC/NMOS_VTH.inc, /nethome/smin63/ECE4130/ECE6130_Updated/ECE6130_LAB/Cadence/INC/NMOS_VTL.inc, /nethome/smin63/ECE4130/ECE6130_Updated/ECE6130_LAB/Cadence/INC/PMOS_THKOX.inc, /nethome/smin63/ECE4130/ECE6130_Updated/ECE6130_LAB/Cadence/INC/PMOS_VTG.inc, /nethome/smin63/ECE4130/ECE6130_Updated/ECE6130_LAB/Cadence/INC/PMOS_VTH.inc, /nethome/smin63/ECE4130/ECE6130_Updated/ECE6130_LAB/Cadence/INC/PMOS_VTL.inc
  Temperature: 27
  Stimulus S0: voltage pulse val0=1 val1=0 period=4n srcType=pulse
  Stimulus S1: voltage pulse val0=1 val1=0 period=6n srcType=pulse
  Stimulus S2: voltage pulse val0=1 val1=0 period=8n srcType=pulse
  Stimulus S3: voltage pulse val0=1 val1=0 period=10n srcType=pulse
  Stimulus vdd!: voltage dc dc=1 srcType=dc
  Analysis tran: stop=10n
  Signals: /S0, /S1, /S2, /S3, /I0, /I1, /I2, /I3, /I4, /I5, /I6, /I7, /I8, /I9, /I10, /I11, /I12, /I13, /I14, /I15
Run mode: Single Run, Sweeps and Corners
