ADE simulation setup
Test ECE4130_Project_4to16Decoder_1: ECE4130_Project/4to16Decoder/schematic, simulator spectre
  Models: /nethome/imix3/ECE4130_M/Project1/ECE6130_Updated/ECE6130_LAB/Cadence/INC/NMOS_THKOX.inc, /nethome/imix3/ECE4130_M/Project1/ECE6130_Updated/ECE6130_LAB/Cadence/INC/NMOS_VTG.inc, /nethome/imix3/ECE4130_M/Project1/ECE6130_Updated/ECE6130_LAB/Cadence/INC/NMOS_VTH.inc, /nethome/imix3/ECE4130_M/Project1/ECE6130_Updated/ECE6130_LAB/Cadence/INC/NMOS_VTL.inc, /nethome/imix3/ECE4130_M/Project1/ECE6130_Updated/ECE6130_LAB/Cadence/INC/PMOS_THKOX.inc, /nethome/imix3/ECE4130_M/Project1/ECE6130_Updated/ECE6130_LAB/Cadence/INC/PMOS_VTG.inc, /nethome/imix3/ECE4130_M/Project1/ECE6130_Updated/ECE6130_LAB/Cadence/INC/PMOS_VTH.inc, /nethome/imix3/ECE4130_M/Project1/ECE6130_Updated/ECE6130_LAB/Cadence/INC/PMOS_VTL.inc
  Temperature: 27
  Stimulus S0: voltage pulse val0=0 val1=800.0m period=2n srcType=pulse
  Stimulus S1: voltage pulse val0=0 val1=800.0m period=4n srcType=pulse
  Stimulus S2: voltage pulse val0=0 val1=800.0m period=8n srcType=pulse
  Stimulus S3: voltage pulse val0=0 val1=800.0m period=16n srcType=pulse
  Stimulus CLK: voltage pulse val0=0 val1=800.0m period=1n rise=100p fall=100p srcType=pulse
  Stimulus vdd!: voltage dc dc=800.0m srcType=dc
  Analysis tran: stop=10n
  Signals: /S0, /S1, /S2, /S3, /WL0, /WL1, /WL2, /WL3, /WL4, /WL5, /WL6, /WL7, /WL8, /WL9, /WL10, /WL11, /WL12, /WL13, /WL14, /WL15, /CLK
Run mode: Single Run, Sweeps and Corners
