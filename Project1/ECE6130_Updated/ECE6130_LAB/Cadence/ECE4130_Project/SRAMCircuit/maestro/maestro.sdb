ADE simulation setup
Run mode: Single Run, Sweeps and Corners
Tests:
  ECE4130_Project_SRAMCircuit_1: ECE4130_Project/SRAMCircuit/schematic, simulator spectre
