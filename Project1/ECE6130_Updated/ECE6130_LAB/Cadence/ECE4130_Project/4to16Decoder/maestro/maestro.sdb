ADE simulation setup
Run mode: Single Run, Sweeps and Corners
Tests:
  ECE4130_Project_4to16Decoder_1: ECE4130_Project/4to16Decoder/schematic, simulator spectre
    Outputs: /WL0; /WL5; "/WL7"
