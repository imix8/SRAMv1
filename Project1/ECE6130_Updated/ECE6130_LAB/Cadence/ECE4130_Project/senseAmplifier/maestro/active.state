ADE simulation setup
Test ECE4130_Project_senseAmplifier_1: ECE4130_Project/senseAmplifier/schematic, simulator spectre
  Models: /nethome/ccarpenter38/ECE6130_Updated/ECE6130_LAB/Cadence/INC/NMOS_THKOX.inc, /nethome/ccarpenter38/ECE6130_Updated/ECE6130_LAB/Cadence/INC/NMOS_VTG.inc, /nethome/ccarpenter38/ECE6130_Updated/ECE6130_LAB/Cadence/INC/NMOS_VTH.inc, /nethome/ccarpenter38/ECE6130_Updated/ECE6130_LAB/Cadence/INC/NMOS_VTL.inc, /nethome/ccarpenter38/ECE6130_Updated/ECE6130_LAB/Cadence/INC/PMOS_THKOX.inc, /nethome/ccarpenter38/ECE6130_Updated/ECE6130_LAB/Cadence/INC/PMOS_VTG.inc, /nethome/ccarpenter38/ECE6130_Updated/ECE6130_LAB/Cadence/INC/PMOS_VTH.inc, /nethome/ccarpenter38/ECE6130_Updated/ECE6130_LAB/Cadence/INC/PMOS_VTL.inc
  Temperature: 27
  Stimulus vdd!: voltage dc dc=600.0m srcType=dc
  Stimulus !VBL: voltage pulse val0=0 val1=600.0m period=2n delay=225p rise=100p fall=100p srcType=pulse
  Stimulus VBL: voltage pulse val0=600.0m val1=0 period=2n delay=225p rise=100p fall=100p srcType=pulse
  Stimulus SAE: voltage pulse val0=600.0m val1=0 period=1n rise=100p fall=100p srcType=pulse
  Analysis tran: stop=3n
  Signals: /OUT, /OUTB, /SAE, /VBL, /!VBL
Run mode: Single Run, Sweeps and Corners
