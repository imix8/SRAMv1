ADE simulation setup
Test ECE4130_Project_RegisterDecoder_1: ECE4130_Project/RegisterDecoder/schematic, simulator spectre
  Models: /nethome/ccarpenter38/ECE4130_M/Project1/ECE6130_Updated/ECE6130_LAB/Cadence/INC/NMOS_THKOX.inc, /nethome/ccarpenter38/ECE4130_M/Project1/ECE6130_Updated/ECE6130_LAB/Cadence/INC/NMOS_VTG.inc, /nethome/ccarpenter38/ECE4130_M/Project1/ECE6130_Updated/ECE6130_LAB/Cadence/INC/NMOS_VTH.inc, /nethome/ccarpenter38/ECE4130_M/Project1/ECE6130_Updated/ECE6130_LAB/Cadence/INC/NMOS_VTL.inc, /nethome/ccarpenter38/ECE4130_M/Project1/ECE6130_Updated/ECE6130_LAB/Cadence/INC/PMOS_THKOX.inc, /nethome/ccarpenter38/ECE4130_M/Project1/ECE6130_Updated/ECE6130_LAB/Cadence/INC/PMOS_VTG.inc, /nethome/ccarpenter38/ECE4130_M/Project1/ECE6130_Updated/ECE6130_LAB/Cadence/INC/PMOS_VTH.inc, /nethome/ccarpenter38/ECE4130_M/Project1/ECE6130_Updated/ECE6130_LAB/Cadence/INC/PMOS_VTL.inc
  Temperature: 27
  Stimulus vdd!: voltage dc dc=675.0m srcType=dc
  Stimulus clk: voltage pulse val0=0 val1=675.0m period=1n rise=100p fall=100p srcType=pulse
  Stimulus rIn0: voltage dc dc=0 srcType=dc
  Stimulus rIn1: voltage pulse dc=0 val0=0 val1=675.0m period=2n delay=-225p rise=100p fall=100p srcType=pulse
  Stimulus rIn2: voltage dc dc=0 srcType=dc
  Stimulus rIn3: voltage dc dc=0 srcType=dc
  Stimulus cIn0: voltage pulse dc=0 val0=0 val1=675.0m period=2n delay=-225p rise=100p fall=100p srcType=pulse
  Stimulus cIn1: voltage dc dc=0 srcType=dc
  Analysis tran: stop=3n
  Signals: /rIn1, /cIn0, /clk, /rWL0, /rWL2, /cWL0, /cWL1
Run mode: Single Run, Sweeps and Corners
