ADE simulation setup
Run mode: Single Run, Sweeps and Corners
Tests:
  ECE4130_Project_2to4DecoderEnable_1: ECE4130_Project/2to4DecoderEnable/schematic, simulator spectre
