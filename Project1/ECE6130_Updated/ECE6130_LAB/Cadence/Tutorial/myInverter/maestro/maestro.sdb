ADE simulation setup
Run mode: Single Run, Sweeps and Corners
Tests:
  Tutorial_myInverter_1: Tutorial/myInverter/schematic, simulator spectre
